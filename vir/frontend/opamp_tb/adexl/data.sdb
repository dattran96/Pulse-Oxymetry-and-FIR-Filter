ADE simulation setup
Run mode: Single Run, Sweeps and Corners
Tests:
  offset: frontend/opamp_tb/config, simulator spectre
  stb: frontend/opamp_tb/config, simulator spectre
  cmrr,noise: frontend/opamp_tb/config, simulator spectre
  swing,icmr: frontend/opamp_tb/config, simulator spectre
  slew,st: frontend/opamp_tb/config, simulator spectre
Global variables:
  VINPUT = 900m
  CL = 2p
  VDD = 1.8
  v_offset = 512.2u
  vcm = 900m
  sigma = 3
Corners:
  model folders: /cadstud/cds03/Cadence_Libraries/UMC_TECH/UMC_65/umc_65_ll_ver_B11PB/Models/Spectre, /cadstud/cds03/Cadence_Libraries/UMC_TECH/UMC_65/umc_65_ll_ver_B11PB/Models/Spectre/Monte_Carlo
  MC (off): l65ll_v181_mc.lib.scs[mc_ll_res, mc_ll_io25od33], L65_MIMCAPS_20F_KF_V101_RF_MC.lib.scs[mc]
  Corner (off): temperature=-25 85; VDD=1.62 1.98; l65ll_v181.lib.scs[ss_ll_io25od33 ff_ll_io25od33 fnsp_ll_io25od33 snfp_ll_io25od33, ff_ll_res ss_ll_res], L65_MIMCAPS_20F_KF_V101_RF.lib.scs[ff ss]
Specs:
  stb / GBW: > 15M
  stb / PM: > 55
  stb / Gain_max: > 60
  slew,st / SR+: > 1M
  slew,st / SR-: > 1M
