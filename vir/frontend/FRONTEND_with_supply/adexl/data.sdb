ADE simulation setup
Run mode: Single Run, Sweeps and Corners
Tests:
  schematic: frontend/FRONTEND_tb/schematic, simulator spectre
  layout: frontend/FRONTEND_tb/config, simulator spectre
Global variables:
  leddrive5 = 1.8
  leddrive4 = 0
  leddrive3 = 1.8
  leddrive2 = 0
  leddrive1 = 0
  leddrive0 = 1.8
  dccomp6 = 1.8
  dccomp5 = 1.8
  dccomp4 = 0
  dccomp3 = 1.8
  dccomp2 = 1.8
  dccomp1 = 1.8
  dccomp0 = 1.8
  Varres3 = 1.8
  Varres2 = 0
  Varres1 = 0
  Varres0 = 1.8
  VDD = 1.8
  VSS = 0
  Vcm = 0.9
