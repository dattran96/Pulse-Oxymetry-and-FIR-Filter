ADE simulation setup
Run mode: Single Run, Sweeps and Corners
Tests:
  frontend:varres_ts:1: frontend/varres_ts/config, simulator spectre
Global variables:
  S0 = 0
  S1 = 0
  S3 = 0
  S2 = 0
  vdd = 1.8
  vss = 0
  sigma = 3
Corners:
  model folders: /cadstud/cds03/Cadence_Libraries/UMC_TECH/UMC_65/umc_65_ll_ver_B11PB/Models/Spectre, /cadstud/cds03/Cadence_Libraries/UMC_TECH/UMC_65/umc_65_ll_ver_B11PB/Models/Spectre/Monte_Carlo
  corner (off): temperature=-25 25 85; vdd=1.62 1.8 1.98; l65ll_v181.lib.scs[ss_ll_io25od33 ff_ll_io25od33 fnsp_ll_io25od33 snfp_ll_io25od33, ff_ll_res ss_ll_res]
  MC (off): l65ll_v181_mc.lib.scs[mc_ll_io25od33, mc_ll_res]
