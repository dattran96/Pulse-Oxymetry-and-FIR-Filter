ADE simulation setup
Run mode: Monte Carlo Sampling
Tests:
  frontend:inverter_tb:1: frontend/inverter_tb/schematic, simulator spectre
Global variables:
  DCin = 900m
  sigma = 3
Corners (nominal off):
  model folders: /cadstud/cds03/Cadence_Libraries/UMC_TECH/UMC_65/umc_65_ll_ver_B11PB/Models/Spectre/Monte_Carlo
  MC: l65ll_v181_mc.lib.scs[mc_ll_io25od33, mc_ll_res, mc_ll_momcaps]
Monte Carlo Sampling options: mcmethod=all, mcnumpoints=200
