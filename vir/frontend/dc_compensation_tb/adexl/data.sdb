ADE simulation setup
Run mode: Single Run, Sweeps and Corners
Tests:
  frontend:dc_compensation_tb:2: frontend/dc_compensation_tb/config, simulator spectre
Global variables:
  S0 = 1.8
  S1 = 1.8
  S2 = 1.8
  S3 = 1.8
  VDD = 1.8
  VSS = 0
  sigma = 3
  S4 = 1.8
  S5 = 1.8
  S6 = 1.8
Corners:
  model folders: /cadstud/cds03/Cadence_Libraries/UMC_TECH/UMC_65/umc_65_ll_ver_B11PB/Models/Spectre, /cadstud/cds03/Cadence_Libraries/UMC_TECH/UMC_65/umc_65_ll_ver_B11PB/Models/Spectre/Monte_Carlo
  MC (off): l65ll_v181_mc.lib.scs[mc_ll_io25od33, mc_ll_res, mc_ll_momcaps]
  Corner (off): temperature=-25 25 85; VDD=1.62 1.8 1.98; l65ll_v181.lib.scs[ss_ll_io25od33 ff_ll_io25od33 fnsp_ll_io25od33 snfp_ll_io25od33, ff_ll_res ss_ll_res]
